* Diode circuit
V1 in 0 DC 1
R1 in out 1k
D1 out 0 Dmod
.model Dmod D(Is=1e-14 N=1)
.op
.end
