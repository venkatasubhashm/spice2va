`include "disciplines.vams"

module my_res(p, n);
    inout p, n;
    electrical p, n;
    parameter real r = 1k;

    analog begin
        V(p, n) <+ r * I(p, n);
    end
endmodule
