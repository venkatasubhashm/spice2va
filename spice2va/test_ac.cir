Title: RC Low Pass Filter
V1 in 0 AC 1
R1 in out 1k
C1 out 0 1u
.ac dec 10 1 10k
.print ac vm(out) vp(out)
.end
